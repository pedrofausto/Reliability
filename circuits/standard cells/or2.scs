// Design: AgingBib/tb_or2
simulator lang=spectre
global 0 vdd!
parameters p5vonly=0 phires=0
include "model/nmos.scs"
include "model/pmos.scs"

V0 (vdd! 0) vsource dc=0.0 type=dc

VInput1 (A 0) vsource type=pulse val0=0 val1=1.1 delay=0 rise=1ps fall=1ps width=20us period=40us
VInput2 (B 0) vsource type=pulse val0=0 val1=1.1 delay=100ns rise=1ps fall=1ps width=20us period=40us

C0 (Y 0) capacitor c=10.0f

// AgingBib/OR2/schematic
subckt OR2 A B Z 0 vdd!
    M0Z (Z net28 0 0) nch w=1.0u l=45n
    M0B (net28 B 0 0) nch w=1.0u l=45n
    M0A (net28 A 0 0) nch w=1.0u l=45n
    M1Z (Z net28 vdd! vdd!) pch w=2.0u l=45n
    M1A (net28 A net34 vdd!) pch w=2.0u l=45n
    M1B (net34 B vdd! vdd!) pch w=2.0u l=45n
ends OR2

// AgingBib/tb_or2/schematic
I1 (A B Y 0 vdd!) OR2

simulatorOptions options temp=0 tnom=70 rforce=0.1 rawfmt=psfxl method=trap
tran tran stop=90us compression=no
saveOptions options save=lvlpub nestlvl=1

*relxpert: age 0h
*relxpert: deltad 0.1
*relxpert: agemethod agemos
*relxpert: degsort
*relxpert: report_model_param
*relxpert: vthmethod spice
**relxpert: agelevel_only [level=101]
**relxpert: new_bo0_format
