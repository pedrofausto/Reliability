// Design: AgingBib/tb_xor2
simulator lang=spectre
global 0 vdd!
parameters p5vonly=0 phires=0
include "model/nmos.scs"
include "model/pmos.scs"

V0 (vdd! 0) vsource dc=0.0 type=dc

VInput1 (A 0) vsource type=pulse val0=0 val1=1.1 delay=0 rise=1ps fall=1ps width=20us period=40us
VInput2 (B 0) vsource type=pulse val0=0 val1=1.1 delay=100ns rise=1ps fall=1ps width=20us period=40us

C0 (Y 0) capacitor c=10.0f

// AgingBib/XOR2/schematic
subckt XOR2 A B Z 0 vdd!
    M0 (net56 A 0 0) nfet l=180.0n w=560.0n nf=1 m=1 gcon=1 rf=0 stis=2 dtemp=0 gns=0
    M0 (Z B net56 0) nfet l=180.0n w=560.0n nf=1 m=1 gcon=1 rf=0 stis=2 dtemp=0 gns=0
    M0 (net36 B 0 0) nfet l=180.0n w=560.0n nf=1 m=1 gcon=1 rf=0 stis=2 dtemp=0 gns=0
    M0 (Z net56 net34 0) nfet l=180.0n w=560.0n nf=1 m=1 gcon=1 rf=0 stis=2 dtemp=0 gns=0
    M0 (net34 net36 0 0) nfet l=180.0n w=560.0n nf=1 m=1 gcon=1 rf=0 stis=2 dtemp=0 gns=0
    M1 (net56 A vdd! vdd!) pfet l=180.0n w=1.06u nf=1 m=1 gcon=1 rf=0 dtemp=0
    M1 (Z net56 net36 vdd!) pfet l=180.0n w=1.06u nf=1 m=1 gcon=1 rf=0 dtemp=0
    M1 (net36 B vdd! vdd!) pfet l=180.0n w=1.06u nf=1 m=1 gcon=1 rf=0 dtemp=0
    M1 (Z net36 net56 vdd!) pfet l=180.0n w=1.06u nf=1 m=1 gcon=1 rf=0 dtemp=0
ends XOR2

// AgingBib/tb_xor2/schematic
I4 (A B Y 0 vdd!) XOR2

simulatorOptions options temp=27
