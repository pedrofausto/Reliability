// Design: AgingBib/tb_xnor2
simulator lang=spectre
global 0 vdd!
parameters p5vonly=0 phires=0
include "model/nmos.scs"
include "model/pmos.scs"

V0 (vdd! 0) vsource dc=0.0 type=dc

VInput1 (A 0) vsource type=pulse val0=0 val1=1.1 delay=0 rise=1ps fall=1ps width=20us period=40us
VInput2 (B 0) vsource type=pulse val0=0 val1=1.1 delay=100ns rise=1ps fall=1ps width=20us period=40us

C0 (Y 0) capacitor c=10.0f

// AgingBib/XNOR2/schematic
subckt XNOR2 A B Z 0 vdd!
    M0A (net76 A 0 0) nfet l=180.0n w=560.0n nf=1 m=1 gcon=1 rf=0 stis=2 dtemp=0 gns=0
    M0Z (Z net76 net75 0) nfet l=180.0n w=560.0n nf=1 m=1 gcon=1 rf=0 stis=2 dtemp=0 gns=0
    M0B (net75 B 0 0) nfet l=180.0n w=560.0n nf=1 m=1 gcon=1 rf=0 stis=2 dtemp=0 gns=0
    M0NB (Z net75 net76 0) nfet l=180.0n w=560.0n nf=1 m=1 gcon=1 rf=0 stis=2 dtemp=0 gns=0
    M1A (net76 A vdd! vdd!) pfet l=180.0n w=1.04u nf=1 m=1 gcon=1 rf=0 dtemp=0
    M1B (Z B net76 vdd!) pfet l=180.0n w=1.04u nf=1 m=1 gcon=1 rf=0 dtemp=0
    M1Z (Z net76 net61 vdd!) pfet l=180.0n w=1.04u nf=1 m=1 gcon=1 rf=0 dtemp=0
    M1NB (net75 B vdd! vdd!) pfet l=180.0n w=1.04u nf=1 m=1 gcon=1 rf=0 dtemp=0
    M1VDD (net61 net75 vdd! vdd!) pfet l=180.0n w=1.04u nf=1 m=1 gcon=1 rf=0 dtemp=0
ends XNOR2

// AgingBib/tb_xnor2/schematic
I5 (A B Y 0 vdd!) XNOR2

simulatorOptions options temp=27
