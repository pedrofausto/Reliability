// Design: AgingLibrary/c1355
simulator lang=spectre
global 0 vdd!
parameters p5vonly=0 phires=0
include "/home/pedrofausto/cadence2/gpdk090_v4.6/libs.oa22/gpdk090/../../models/spectre/gpdk090.scs" section=NN

// AgingLibrary/AND2/schematic
subckt AND2 A B Z inh_gnd inh_vdd
    TNA (net29 A net34 inh_gnd) nch w=1.0u l=45n
    TNB (net34 B inh_gnd inh_gnd) nch w=1.0u l=45n
    TNZ (Z net29 inh_gnd inh_gnd) nch w=1.0u l=45n
    TPB (net29 B inh_vdd inh_vdd) pch w=2.0u l=45n
    TPA (net29 A inh_vdd inh_vdd) pch w=2.0u l=45n
    TPZ (Z net29 inh_vdd inh_vdd) pch w=2.0u l=45n
ends AND2

// AgingLibrary/NAND2/schematic
subckt NAND2 A B Z inh_gnd inh_vdd
    TNA (Z A net20 inh_gnd) nch w=1.0u l=45n
    TNB (net20 B inh_gnd inh_gnd) nch w=1.0u l=45n
    TPA (Z A inh_vdd inh_vdd) pch w=2.0u l=45n
    TPB (Z B inh_vdd inh_vdd) pch w=2.0u l=45n
ends NAND2

// AgingLibrary/OR2/schematic
subckt OR2 A B Z inh_gnd inh_vdd
    TNZ (Z net28 inh_gnd inh_gnd) nch w=1.0u l=45n
    TNB (net28 B inh_gnd inh_gnd) nch w=1.0u l=45n
    TNA (net28 A inh_gnd inh_gnd) nch w=1.0u l=45n
    TPZ (Z net28 inh_vdd inh_vdd) pch w=2.0u l=45n
    TPA (net28 A net34 inh_vdd) pch w=2.0u l=45n
    TPB (net34 B inh_vdd inh_vdd) pch w=2.0u l=45n
ends OR2

// AgingLibrary/INV/schematic
subckt INV A Z inh_gnd inh_vdd
    TNA (Z A inh_gnd inh_gnd) nch w=1.0u l=45n
    TPA (Z A inh_vdd inh_vdd) pch w=2.0u l=45n
ends INV

// AgingLibrary/NOR2/schematic
subckt NOR2 A B Z inh_gnd inh_vdd
    TNA (Z A inh_gnd inh_gnd) nch w=1.0u l=45n
    TNB (Z B inh_gnd inh_gnd) nch w=1.0u l=45n
    TPA (Z A net18 inh_vdd) pch w=2.0u l=45n
    TPB (net18 B inh_vdd inh_vdd) pch w=2.0u l=45n
ends NOR2

// AgingLibrary/c1355/schematic
U387 (n_263 n_262 n_264 0 vdd!) AND2
U389 (n_257 n_255 n_258 0 vdd!) AND2
U386 (n_266 n_265 n_268 0 vdd!) AND2
U370 (n_319 n_318 n_320 0 vdd!) AND2
U369 (n_323 n_321 n_324 0 vdd!) AND2
U423 (n_694 n_677 n_212 0 vdd!) AND2
U411 (n_714 n_677 n_227 0 vdd!) AND2
U419 (n_701 n_676 n_216 0 vdd!) AND2
U415 (n_707 n_676 n_220 0 vdd!) AND2
U422 (n_695 n_645 n_213 0 vdd!) AND2
U418 (n_702 n_643 n_217 0 vdd!) AND2
U414 (n_708 n_643 n_221 0 vdd!) AND2
U410 (n_715 n_646 n_228 0 vdd!) AND2
U280 (n_673 X_231gat n_512 0 vdd!) AND2
U373 (n_309 n_308 n_310 0 vdd!) AND2
U374 (n_306 n_305 n_307 0 vdd!) AND2
U364 (n_336 n_335 n_337 0 vdd!) AND2
U363 (n_339 n_338 n_340 0 vdd!) AND2
U240 (n_601 n_599 n_627 0 vdd!) AND2
U372 (n_313 n_312 n_314 0 vdd!) AND2
U52 (n_313 n_312 n_311 0 vdd!) AND2
U421 (n_695 n_653 n_214 0 vdd!) AND2
U420 (n_694 n_641 n_215 0 vdd!) AND2
U417 (n_702 n_653 n_218 0 vdd!) AND2
U416 (n_701 n_639 n_219 0 vdd!) AND2
U237 (n_609 n_544 n_610 0 vdd!) AND2
U293 (n_659 n_690 n_609 0 vdd!) AND2
U371 (n_316 n_315 n_317 0 vdd!) AND2
U396 (n_739 n_663 n_246 0 vdd!) AND2
U361 (n_346 n_344 n_347 0 vdd!) AND2
U359 (n_352 n_351 n_353 0 vdd!) AND2
U358 (n_355 n_354 n_357 0 vdd!) AND2
U291 (n_685 n_669 n_503 0 vdd!) AND2
U290 (n_367 n_503 n_613 0 vdd!) AND2
U407 (n_232 n_231 n_233 0 vdd!) AND2
U243 (n_590 n_588 n_617 0 vdd!) AND2
U285 (n_635 X_225gat n_506 0 vdd!) AND2
U360 (n_349 n_348 n_350 0 vdd!) AND2
U292 (n_663 n_631 n_612 0 vdd!) AND2
U239 (n_603 n_602 n_624 0 vdd!) AND2
U413 (n_708 n_656 n_224 0 vdd!) AND2
U409 (n_715 n_654 n_229 0 vdd!) AND2
U408 (n_714 n_638 n_230 0 vdd!) AND2
U412 (n_707 n_638 n_225 0 vdd!) AND2
U333 (n_416 n_415 n_417 0 vdd!) AND2
U352 (n_371 n_370 n_372 0 vdd!) AND2
U38 (n_374 n_373 n_467 0 vdd!) AND2
U233 (n_624 n_640 n_625 0 vdd!) AND2
U382 (n_280 n_279 n_281 0 vdd!) AND2
U384 (n_273 n_272 n_274 0 vdd!) AND2
U381 (n_283 n_282 n_284 0 vdd!) AND2
U397 (n_739 n_669 n_244 0 vdd!) AND2
U288 (n_619 n_618 n_615 0 vdd!) AND2
U406 (n_720 n_660 n_235 0 vdd!) AND2
U405 (n_721 n_211 n_236 0 vdd!) AND2
U402 (n_727 n_658 n_239 0 vdd!) AND2
U401 (n_728 n_668 n_240 0 vdd!) AND2
U398 (n_738 n_658 n_243 0 vdd!) AND2
U393 (n_746 n_211 n_249 0 vdd!) AND2
U394 (n_745 n_660 n_248 0 vdd!) AND2
U395 (n_738 n_649 n_247 0 vdd!) AND2
U404 (n_721 n_245 n_237 0 vdd!) AND2
U403 (n_720 n_651 n_238 0 vdd!) AND2
U49 (n_316 n_315 n_345 0 vdd!) AND2
U367 (n_327 n_326 n_328 0 vdd!) AND2
U366 (n_330 n_329 n_331 0 vdd!) AND2
U287 (n_625 n_511 n_616 0 vdd!) AND2
U286 (n_647 n_734 n_621 0 vdd!) AND2
U234 (n_621 n_456 n_623 0 vdd!) AND2
U232 (n_665 n_650 n_628 0 vdd!) AND2
U231 (n_630 n_629 n_631 0 vdd!) AND2
U242 (n_594 n_593 n_595 0 vdd!) AND2
U282 (n_632 X_229gat n_509 0 vdd!) AND2
U383 (n_276 n_275 n_277 0 vdd!) AND2
U399 (n_727 n_649 n_242 0 vdd!) AND2
U392 (n_746 n_245 n_250 0 vdd!) AND2
U391 (n_745 n_651 n_251 0 vdd!) AND2
U306 (n_480 n_479 n_481 0 vdd!) AND2
U400 (n_728 n_662 n_241 0 vdd!) AND2
U314 (n_462 n_461 n_463 0 vdd!) AND2
U5 (n_465 n_464 n_334 0 vdd!) AND2
U313 (n_465 n_464 n_466 0 vdd!) AND2
U351 (n_374 n_373 n_375 0 vdd!) AND2
U345 (n_387 n_386 n_388 0 vdd!) AND2
U344 (n_391 n_390 n_392 0 vdd!) AND2
U40 (n_371 n_370 n_444 0 vdd!) AND2
U350 (n_377 n_376 n_379 0 vdd!) AND2
U349 (n_381 n_380 n_382 0 vdd!) AND2
U18 (n_416 n_415 n_689 0 vdd!) AND2
U331 (n_423 n_421 n_424 0 vdd!) AND2
U330 (n_426 n_425 n_427 0 vdd!) AND2
U316 (n_455 n_454 n_457 0 vdd!) AND2
U300 (n_491 n_490 n_492 0 vdd!) AND2
U299 (n_494 n_493 n_495 0 vdd!) AND2
U326 (n_432 n_431 n_434 0 vdd!) AND2
U325 (n_436 n_435 n_437 0 vdd!) AND2
U388 (n_260 n_259 n_261 0 vdd!) AND2
U284 (n_673 X_226gat n_507 0 vdd!) AND2
U378 (n_293 n_292 n_294 0 vdd!) AND2
U281 (X_230gat n_674 n_510 0 vdd!) AND2
U278 (n_634 X_228gat n_514 0 vdd!) AND2
U334 (n_413 n_412 n_414 0 vdd!) AND2
U353 (n_368 n_366 n_369 0 vdd!) AND2
U279 (n_680 X_227gat n_513 0 vdd!) AND2
U332 (n_419 n_418 n_420 0 vdd!) AND2
U16 (n_419 n_418 n_711 0 vdd!) AND2
U354 (n_364 n_363 n_365 0 vdd!) AND2
U340 (n_397 n_396 n_398 0 vdd!) AND2
U339 (n_401 n_399 n_402 0 vdd!) AND2
U3 (n_462 n_461 n_556 0 vdd!) AND2
U312 (n_469 n_468 n_470 0 vdd!) AND2
U311 (n_472 n_471 n_473 0 vdd!) AND2
U379 (n_290 n_288 n_291 0 vdd!) AND2
U377 (n_296 n_295 n_297 0 vdd!) AND2
U376 (n_299 n_298 n_301 0 vdd!) AND2
U335 (n_409 n_408 n_410 0 vdd!) AND2
U321 (n_442 n_441 n_443 0 vdd!) AND2
U320 (n_447 n_446 n_448 0 vdd!) AND2
U277 (n_234 X_232gat n_515 0 vdd!) AND2
U315 (n_459 n_458 n_460 0 vdd!) AND2
U238 (n_607 n_606 n_629 0 vdd!) AND2
U241 (n_597 n_596 n_598 0 vdd!) AND2
U305 (n_483 n_482 n_484 0 vdd!) AND2
U216 (n_592 n_591 n_648 0 vdd!) AND2
U196 (n_592 n_591 n_671 0 vdd!) AND2
U221 (n_605 n_604 n_642 0 vdd!) AND2
U195 (n_605 n_604 n_672 0 vdd!) AND2
U451 (n_264 n_268 n_257 0 vdd!) NAND2
U667 (n_263 n_262 n_184 0 vdd!) NAND2
U664 (n_266 n_265 n_183 0 vdd!) NAND2
U450 (n_184 n_183 n_255 0 vdd!) NAND2
U275 (n_518 n_517 X_1324gat 0 vdd!) NAND2
U263 (n_545 n_543 X_1336gat 0 vdd!) NAND2
U271 (n_527 n_526 X_1328gat 0 vdd!) NAND2
U274 (n_520 n_519 X_1325gat 0 vdd!) NAND2
U270 (n_529 n_528 X_1329gat 0 vdd!) NAND2
U266 (n_538 n_537 X_1333gat 0 vdd!) NAND2
U262 (n_547 n_546 X_1337gat 0 vdd!) NAND2
U267 (n_536 n_535 X_1332gat 0 vdd!) NAND2
U462 (n_320 n_324 n_313 0 vdd!) NAND2
U631 (n_319 n_318 n_173 0 vdd!) NAND2
U461 (n_173 n_172 n_312 0 vdd!) NAND2
U628 (n_323 n_321 n_172 0 vdd!) NAND2
U375 (n_303 n_302 n_304 0 vdd!) NAND2
U471 (X_231gat n_234 n_163 0 vdd!) NAND2
U472 (n_310 n_163 n_303 0 vdd!) NAND2
U634 (n_309 n_308 n_164 0 vdd!) NAND2
U470 (n_512 n_164 n_302 0 vdd!) NAND2
U467 (n_337 n_340 n_306 0 vdd!) NAND2
U619 (n_336 n_335 n_169 0 vdd!) NAND2
U616 (n_339 n_338 n_168 0 vdd!) NAND2
U466 (n_169 n_168 n_305 0 vdd!) NAND2
U257 (n_559 n_558 X_1342gat 0 vdd!) NAND2
U273 (n_523 n_521 X_1326gat 0 vdd!) NAND2
U272 (n_525 n_524 X_1327gat 0 vdd!) NAND2
U269 (n_531 n_530 X_1330gat 0 vdd!) NAND2
U268 (n_534 n_532 X_1331gat 0 vdd!) NAND2
U635 (n_307 n_304 n_599 0 vdd!) NAND2
U249 (n_576 n_575 X_1350gat 0 vdd!) NAND2
U173 (n_608 n_610 n_696 0 vdd!) NAND2
U167 (n_610 n_367 n_703 0 vdd!) NAND2
U607 (n_352 n_351 n_193 0 vdd!) NAND2
U604 (n_355 n_354 n_192 0 vdd!) NAND2
U442 (n_353 n_357 n_346 0 vdd!) NAND2
U441 (n_193 n_192 n_344 0 vdd!) NAND2
U155 (n_614 n_613 n_716 0 vdd!) NAND2
U512 (n_124 n_125 n_614 0 vdd!) NAND2
U511 (n_233 n_617 n_124 0 vdd!) NAND2
U611 (n_347 n_343 n_588 0 vdd!) NAND2
U362 (n_342 n_341 n_343 0 vdd!) NAND2
U448 (X_225gat n_680 n_185 0 vdd!) NAND2
U449 (n_350 n_185 n_342 0 vdd!) NAND2
U610 (n_349 n_348 n_186 0 vdd!) NAND2
U447 (n_506 n_186 n_341 0 vdd!) NAND2
U265 (n_540 n_539 X_1334gat 0 vdd!) NAND2
U261 (n_549 n_548 X_1338gat 0 vdd!) NAND2
U260 (n_551 n_550 X_1339gat 0 vdd!) NAND2
U264 (n_542 n_541 X_1335gat 0 vdd!) NAND2
U31 (n_124 n_125 n_544 0 vdd!) NAND2
U161 (n_612 n_544 n_709 0 vdd!) NAND2
U705 (n_647 n_104 n_231 0 vdd!) NAND2
U599 (n_365 n_362 n_602 0 vdd!) NAND2
U510 (n_505 n_511 n_125 0 vdd!) NAND2
U474 (n_281 n_284 n_273 0 vdd!) NAND2
U655 (n_280 n_279 n_162 0 vdd!) NAND2
U652 (n_283 n_282 n_161 0 vdd!) NAND2
U473 (n_162 n_161 n_272 0 vdd!) NAND2
U259 (n_553 n_552 X_1340gat 0 vdd!) NAND2
U258 (n_557 n_554 X_1341gat 0 vdd!) NAND2
U254 (n_565 n_564 X_1345gat 0 vdd!) NAND2
U255 (n_563 n_562 X_1344gat 0 vdd!) NAND2
U251 (n_572 n_571 X_1348gat 0 vdd!) NAND2
U250 (n_574 n_573 X_1349gat 0 vdd!) NAND2
U246 (n_583 n_582 X_1353gat 0 vdd!) NAND2
U247 (n_581 n_580 X_1352gat 0 vdd!) NAND2
U133 (n_478 n_623 n_740 0 vdd!) NAND2
U149 (n_615 n_456 n_723 0 vdd!) NAND2
U625 (n_327 n_326 n_166 0 vdd!) NAND2
U622 (n_330 n_329 n_165 0 vdd!) NAND2
U469 (n_328 n_331 n_316 0 vdd!) NAND2
U468 (n_166 n_165 n_315 0 vdd!) NAND2
U256 (n_561 n_560 X_1343gat 0 vdd!) NAND2
U143 (n_616 n_620 n_729 0 vdd!) NAND2
U483 (n_152 n_153 n_620 0 vdd!) NAND2
U127 (n_623 n_411 n_747 0 vdd!) NAND2
U39 (n_152 n_153 n_456 0 vdd!) NAND2
U480 (n_155 n_158 n_154 0 vdd!) NAND2
U478 (n_300 n_157 n_158 0 vdd!) NAND2
U482 (n_598 n_154 n_152 0 vdd!) NAND2
U479 (n_628 n_685 n_155 0 vdd!) NAND2
U481 (n_631 n_256 n_153 0 vdd!) NAND2
U659 (n_274 n_271 n_593 0 vdd!) NAND2
U385 (n_270 n_269 n_271 0 vdd!) NAND2
U476 (X_229gat n_636 n_159 0 vdd!) NAND2
U477 (n_277 n_159 n_270 0 vdd!) NAND2
U658 (n_276 n_275 n_160 0 vdd!) NAND2
U475 (n_509 n_160 n_269 0 vdd!) NAND2
U252 (n_570 n_569 X_1347gat 0 vdd!) NAND2
U253 (n_568 n_566 X_1346gat 0 vdd!) NAND2
U434 (n_199 n_198 n_464 0 vdd!) NAND2
U542 (n_480 n_479 n_199 0 vdd!) NAND2
U435 (n_481 n_484 n_465 0 vdd!) NAND2
U589 (n_387 n_386 n_191 0 vdd!) NAND2
U586 (n_391 n_390 n_190 0 vdd!) NAND2
U444 (n_388 n_392 n_374 0 vdd!) NAND2
U443 (n_191 n_190 n_373 0 vdd!) NAND2
U595 (n_377 n_376 n_182 0 vdd!) NAND2
U592 (n_381 n_380 n_181 0 vdd!) NAND2
U453 (n_379 n_382 n_371 0 vdd!) NAND2
U452 (n_182 n_181 n_370 0 vdd!) NAND2
U248 (n_579 n_577 X_1351gat 0 vdd!) NAND2
U244 (n_587 n_586 X_1355gat 0 vdd!) NAND2
U245 (n_585 n_584 X_1354gat 0 vdd!) NAND2
U569 (n_426 n_425 n_179 0 vdd!) NAND2
U572 (n_423 n_421 n_180 0 vdd!) NAND2
U454 (n_180 n_179 n_415 0 vdd!) NAND2
U455 (n_424 n_427 n_416 0 vdd!) NAND2
U533 (n_494 n_493 n_201 0 vdd!) NAND2
U536 (n_491 n_490 n_202 0 vdd!) NAND2
U432 (n_202 n_201 n_454 0 vdd!) NAND2
U433 (n_492 n_495 n_455 0 vdd!) NAND2
U566 (n_432 n_431 n_188 0 vdd!) NAND2
U446 (n_434 n_437 n_419 0 vdd!) NAND2
U563 (n_436 n_435 n_187 0 vdd!) NAND2
U445 (n_188 n_187 n_418 0 vdd!) NAND2
U670 (n_260 n_259 n_177 0 vdd!) NAND2
U456 (n_507 n_177 n_252 0 vdd!) NAND2
U390 (n_253 n_252 n_254 0 vdd!) NAND2
U457 (X_226gat n_189 n_176 0 vdd!) NAND2
U458 (n_261 n_176 n_253 0 vdd!) NAND2
U380 (n_286 n_285 n_287 0 vdd!) NAND2
U465 (n_294 n_170 n_286 0 vdd!) NAND2
U646 (n_293 n_292 n_171 0 vdd!) NAND2
U463 (n_510 n_171 n_285 0 vdd!) NAND2
U464 (n_189 X_230gat n_170 0 vdd!) NAND2
U493 (n_414 n_143 n_406 0 vdd!) NAND2
U336 (n_406 n_405 n_407 0 vdd!) NAND2
U492 (X_228gat n_674 n_143 0 vdd!) NAND2
U491 (n_514 n_144 n_405 0 vdd!) NAND2
U575 (n_413 n_412 n_144 0 vdd!) NAND2
U487 (X_227gat n_634 n_148 0 vdd!) NAND2
U355 (n_361 n_360 n_362 0 vdd!) NAND2
U486 (n_513 n_149 n_360 0 vdd!) NAND2
U488 (n_369 n_148 n_361 0 vdd!) NAND2
U598 (n_368 n_366 n_149 0 vdd!) NAND2
U583 (n_397 n_396 n_151 0 vdd!) NAND2
U580 (n_401 n_399 n_150 0 vdd!) NAND2
U485 (n_398 n_402 n_364 0 vdd!) NAND2
U484 (n_151 n_150 n_363 0 vdd!) NAND2
U548 (n_469 n_468 n_197 0 vdd!) NAND2
U545 (n_472 n_471 n_196 0 vdd!) NAND2
U437 (n_470 n_473 n_462 0 vdd!) NAND2
U436 (n_197 n_196 n_461 0 vdd!) NAND2
U643 (n_296 n_295 n_175 0 vdd!) NAND2
U640 (n_299 n_298 n_174 0 vdd!) NAND2
U460 (n_297 n_301 n_290 0 vdd!) NAND2
U459 (n_175 n_174 n_288 0 vdd!) NAND2
U560 (n_442 n_441 n_147 0 vdd!) NAND2
U557 (n_447 n_446 n_146 0 vdd!) NAND2
U490 (n_443 n_448 n_409 0 vdd!) NAND2
U489 (n_147 n_146 n_408 0 vdd!) NAND2
U317 (n_452 n_451 n_453 0 vdd!) NAND2
U551 (n_459 n_458 n_195 0 vdd!) NAND2
U438 (n_515 n_195 n_451 0 vdd!) NAND2
U440 (n_460 n_194 n_452 0 vdd!) NAND2
U439 (X_232gat n_636 n_194 0 vdd!) NAND2
U552 (n_457 n_453 n_606 0 vdd!) NAND2
U647 (n_291 n_287 n_596 0 vdd!) NAND2
U671 (n_258 n_254 n_591 0 vdd!) NAND2
U539 (n_483 n_482 n_198 0 vdd!) NAND2
U576 (n_410 n_407 n_604 0 vdd!) NAND2
U738 (n_105 n_683 n_518 0 vdd!) OR2
U737 (n_358 n_212 n_517 0 vdd!) OR2
U714 (n_119 n_756 n_545 0 vdd!) OR2
U713 (n_475 n_227 n_543 0 vdd!) OR2
U624 (n_389 n_682 n_327 0 vdd!) OR2
U605 (n_400 n_704 n_351 0 vdd!) OR2
U730 (n_109 n_705 n_527 0 vdd!) OR2
U729 (n_486 n_216 n_526 0 vdd!) OR2
U736 (n_106 n_687 n_520 0 vdd!) OR2
U735 (n_332 n_213 n_519 0 vdd!) OR2
U728 (n_110 n_712 n_529 0 vdd!) OR2
U727 (n_485 n_217 n_528 0 vdd!) OR2
U540 (n_700 n_712 n_479 0 vdd!) OR2
U541 (n_722 n_705 n_480 0 vdd!) OR2
U720 (n_116 n_736 n_538 0 vdd!) OR2
U719 (n_325 n_221 n_537 0 vdd!) OR2
U712 (n_120 n_762 n_547 0 vdd!) OR2
U711 (n_474 n_228 n_546 0 vdd!) OR2
U630 (n_356 n_730 n_319 0 vdd!) OR2
U722 (n_115 n_731 n_536 0 vdd!) OR2
U721 (n_359 n_220 n_535 0 vdd!) OR2
U602 (n_433 n_754 n_354 0 vdd!) OR2
U546 (n_83 n_762 n_468 0 vdd!) OR2
U547 (n_112 n_756 n_469 0 vdd!) OR2
U623 (n_358 n_687 n_326 0 vdd!) OR2
U603 (n_475 n_731 n_355 0 vdd!) OR2
U606 (n_486 n_683 n_352 0 vdd!) OR2
U666 (n_485 n_686 n_263 0 vdd!) OR2
U665 (n_332 n_710 n_262 0 vdd!) OR2
U663 (n_474 n_735 n_266 0 vdd!) OR2
U662 (n_325 n_761 n_265 0 vdd!) OR2
U629 (n_359 n_736 n_318 0 vdd!) OR2
U627 (n_450 n_741 n_323 0 vdd!) OR2
U626 (n_404 n_748 n_321 0 vdd!) OR2
U699 (n_395 n_237 n_558 0 vdd!) OR2
U700 (n_128 n_90 n_559 0 vdd!) OR2
U734 (n_107 n_692 n_523 0 vdd!) OR2
U733 (n_403 n_214 n_521 0 vdd!) OR2
U732 (n_108 n_698 n_525 0 vdd!) OR2
U731 (n_449 n_215 n_524 0 vdd!) OR2
U581 (n_644 n_717 n_396 0 vdd!) OR2
U726 (n_113 n_718 n_531 0 vdd!) OR2
U725 (n_488 n_218 n_530 0 vdd!) OR2
U558 (n_667 n_724 n_441 0 vdd!) OR2
U724 (n_114 n_725 n_534 0 vdd!) OR2
U723 (n_487 n_219 n_532 0 vdd!) OR2
U537 (n_655 n_725 n_482 0 vdd!) OR2
U538 (n_678 n_718 n_483 0 vdd!) OR2
U636 (n_304 n_307 n_601 0 vdd!) OR2
U684 (n_137 n_80 n_576 0 vdd!) OR2
U683 (n_385 n_246 n_575 0 vdd!) OR2
U590 (n_555 n_73 n_380 0 vdd!) OR2
U632 (n_210 n_314 n_308 0 vdd!) OR2
U633 (n_208 n_317 n_309 0 vdd!) OR2
U644 (n_208 n_556 n_292 0 vdd!) OR2
U620 (n_403 n_697 n_329 0 vdd!) OR2
U621 (n_449 n_691 n_330 0 vdd!) OR2
U582 (n_488 n_692 n_397 0 vdd!) OR2
U559 (n_487 n_698 n_442 0 vdd!) OR2
U618 (n_440 n_89 n_336 0 vdd!) OR2
U617 (n_395 n_123 n_335 0 vdd!) OR2
U615 (n_430 n_79 n_339 0 vdd!) OR2
U614 (n_385 n_758 n_338 0 vdd!) OR2
U645 (n_207 n_311 n_293 0 vdd!) OR2
U550 (n_207 n_466 n_459 0 vdd!) OR2
U591 (n_499 n_80 n_381 0 vdd!) OR2
U276 (n_411 n_478 n_516 0 vdd!) OR2
U706 (n_516 n_645 n_232 0 vdd!) OR2
U612 (n_343 n_347 n_590 0 vdd!) OR2
U718 (n_117 n_742 n_540 0 vdd!) OR2
U717 (n_404 n_224 n_539 0 vdd!) OR2
U578 (n_666 n_768 n_399 0 vdd!) OR2
U710 (n_121 n_769 n_549 0 vdd!) OR2
U709 (n_477 n_229 n_548 0 vdd!) OR2
U543 (n_744 n_775 n_471 0 vdd!) OR2
U544 (n_766 n_769 n_472 0 vdd!) OR2
U708 (n_122 n_775 n_551 0 vdd!) OR2
U707 (n_476 n_230 n_550 0 vdd!) OR2
U555 (n_778 n_774 n_446 0 vdd!) OR2
U715 (n_450 n_225 n_541 0 vdd!) OR2
U716 (n_118 n_749 n_542 0 vdd!) OR2
U529 (n_639 n_656 n_104 0 vdd!) OR2
U600 (n_362 n_365 n_603 0 vdd!) OR2
U608 (n_206 n_711 n_348 0 vdd!) OR2
U573 (n_205 n_417 n_412 0 vdd!) OR2
U596 (n_206 n_372 n_366 0 vdd!) OR2
U579 (n_477 n_742 n_401 0 vdd!) OR2
U556 (n_476 n_749 n_447 0 vdd!) OR2
U609 (n_205 n_467 n_349 0 vdd!) OR2
U704 (n_126 n_77 n_553 0 vdd!) OR2
U703 (n_394 n_235 n_552 0 vdd!) OR2
U588 (n_578 n_77 n_387 0 vdd!) OR2
U587 (n_600 n_84 n_386 0 vdd!) OR2
U702 (n_127 n_84 n_557 0 vdd!) OR2
U701 (n_393 n_236 n_554 0 vdd!) OR2
U694 (n_131 n_167 n_565 0 vdd!) OR2
U693 (n_438 n_240 n_564 0 vdd!) OR2
U565 (n_94 n_103 n_432 0 vdd!) OR2
U564 (n_223 n_167 n_431 0 vdd!) OR2
U696 (n_130 n_103 n_563 0 vdd!) OR2
U695 (n_439 n_239 n_562 0 vdd!) OR2
U688 (n_135 n_93 n_572 0 vdd!) OR2
U687 (n_384 n_243 n_571 0 vdd!) OR2
U593 (n_533 n_87 n_376 0 vdd!) OR2
U594 (n_500 n_93 n_377 0 vdd!) OR2
U686 (n_136 n_87 n_574 0 vdd!) OR2
U685 (n_383 n_244 n_573 0 vdd!) OR2
U678 (n_140 n_765 n_583 0 vdd!) OR2
U677 (n_428 n_249 n_582 0 vdd!) OR2
U680 (n_139 n_772 n_581 0 vdd!) OR2
U679 (n_429 n_248 n_580 0 vdd!) OR2
U571 (n_733 n_772 n_423 0 vdd!) OR2
U570 (n_755 n_765 n_421 0 vdd!) OR2
U642 (n_438 n_82 n_296 0 vdd!) OR2
U641 (n_393 n_156 n_295 0 vdd!) OR2
U654 (n_439 n_76 n_280 0 vdd!) OR2
U653 (n_394 n_102 n_279 0 vdd!) OR2
U651 (n_429 n_92 n_283 0 vdd!) OR2
U650 (n_384 n_771 n_282 0 vdd!) OR2
U639 (n_428 n_86 n_299 0 vdd!) OR2
U638 (n_383 n_764 n_298 0 vdd!) OR2
U698 (n_129 n_97 n_561 0 vdd!) OR2
U697 (n_497 n_238 n_560 0 vdd!) OR2
U530 (n_665 n_595 n_157 0 vdd!) OR2
U660 (n_271 n_274 n_594 0 vdd!) OR2
U535 (n_633 n_97 n_491 0 vdd!) OR2
U534 (n_611 n_100 n_490 0 vdd!) OR2
U690 (n_133 n_100 n_570 0 vdd!) OR2
U689 (n_496 n_242 n_569 0 vdd!) OR2
U561 (n_445 n_99 n_435 0 vdd!) OR2
U691 (n_440 n_241 n_566 0 vdd!) OR2
U692 (n_132 n_134 n_568 0 vdd!) OR2
U584 (n_622 n_96 n_390 0 vdd!) OR2
U585 (n_497 n_90 n_391 0 vdd!) OR2
U656 (n_210 n_334 n_275 0 vdd!) OR2
U549 (n_209 n_463 n_458 0 vdd!) OR2
U562 (n_496 n_134 n_436 0 vdd!) OR2
U657 (n_209 n_345 n_276 0 vdd!) OR2
U682 (n_138 n_74 n_579 0 vdd!) OR2
U681 (n_499 n_247 n_577 0 vdd!) OR2
U674 (n_142 n_752 n_587 0 vdd!) OR2
U673 (n_498 n_251 n_586 0 vdd!) OR2
U675 (n_430 n_250 n_584 0 vdd!) OR2
U676 (n_141 n_759 n_585 0 vdd!) OR2
U597 (n_204 n_375 n_368 0 vdd!) OR2
U531 (n_567 n_752 n_493 0 vdd!) OR2
U532 (n_589 n_74 n_494 0 vdd!) OR2
U567 (n_777 n_751 n_425 0 vdd!) OR2
U574 (n_203 n_420 n_413 0 vdd!) OR2
U568 (n_498 n_759 n_426 0 vdd!) OR2
U668 (n_204 n_689 n_259 0 vdd!) OR2
U669 (n_203 n_444 n_260 0 vdd!) OR2
U553 (n_453 n_457 n_607 0 vdd!) OR2
U648 (n_287 n_291 n_597 0 vdd!) OR2
U672 (n_254 n_258 n_592 0 vdd!) OR2
U577 (n_407 n_410 n_605 0 vdd!) OR2
U528 (n_212 n_105 0 vdd!) INV
U516 (n_227 n_119 0 vdd!) INV
U45 (X_8gat n_389 0 vdd!) INV
U180 (X_8gat n_688 0 vdd!) INV
U184 (X_1gat n_684 0 vdd!) INV
U44 (X_1gat n_400 0 vdd!) INV
U524 (n_216 n_109 0 vdd!) INV
U527 (n_213 n_106 0 vdd!) INV
U523 (n_217 n_110 0 vdd!) INV
U164 (X_29gat n_706 0 vdd!) INV
U17 (X_29gat n_700 0 vdd!) INV
U158 (X_36gat n_713 0 vdd!) INV
U15 (X_36gat n_722 0 vdd!) INV
U519 (n_221 n_116 0 vdd!) INV
U515 (n_228 n_120 0 vdd!) INV
U136 (X_64gat n_737 0 vdd!) INV
U48 (X_64gat n_356 0 vdd!) INV
U520 (n_220 n_115 0 vdd!) INV
U140 (X_57gat n_732 0 vdd!) INV
U41 (X_57gat n_433 0 vdd!) INV
U118 (X_85gat n_757 0 vdd!) INV
U9 (X_85gat n_83 0 vdd!) INV
U112 (X_92gat n_763 0 vdd!) INV
U7 (X_92gat n_112 0 vdd!) INV
U357 (n_682 n_358 0 vdd!) INV
U190 (n_679 n_677 0 vdd!) INV
U309 (n_754 n_475 0 vdd!) INV
U191 (n_679 n_676 0 vdd!) INV
U189 (n_226 n_679 0 vdd!) INV
U613 (n_617 n_226 0 vdd!) INV
U139 (n_226 n_734 0 vdd!) INV
U186 (n_684 n_682 0 vdd!) INV
U185 (n_684 n_683 0 vdd!) INV
U303 (n_704 n_486 0 vdd!) INV
U166 (n_706 n_704 0 vdd!) INV
U181 (n_688 n_687 0 vdd!) INV
U182 (n_688 n_686 0 vdd!) INV
U365 (n_686 n_332 0 vdd!) INV
U304 (n_710 n_485 0 vdd!) INV
U160 (n_713 n_710 0 vdd!) INV
U165 (n_706 n_705 0 vdd!) INV
U159 (n_713 n_712 0 vdd!) INV
U368 (n_735 n_325 0 vdd!) INV
U138 (n_737 n_735 0 vdd!) INV
U218 (n_671 n_643 0 vdd!) INV
U310 (n_761 n_474 0 vdd!) INV
U114 (n_763 n_761 0 vdd!) INV
U137 (n_737 n_736 0 vdd!) INV
U356 (n_730 n_359 0 vdd!) INV
U142 (n_732 n_730 0 vdd!) INV
U141 (n_732 n_731 0 vdd!) INV
U120 (n_757 n_754 0 vdd!) INV
U119 (n_757 n_756 0 vdd!) INV
U113 (n_763 n_762 0 vdd!) INV
U507 (n_237 n_128 0 vdd!) INV
U526 (n_214 n_107 0 vdd!) INV
U525 (n_215 n_108 0 vdd!) INV
U176 (X_15gat n_693 0 vdd!) INV
U22 (X_15gat n_644 0 vdd!) INV
U522 (n_218 n_113 0 vdd!) INV
U170 (X_22gat n_699 0 vdd!) INV
U2 (X_22gat n_667 0 vdd!) INV
U521 (n_219 n_114 0 vdd!) INV
U152 (X_43gat n_719 0 vdd!) INV
U21 (X_43gat n_655 0 vdd!) INV
U146 (X_50gat n_726 0 vdd!) INV
U19 (X_50gat n_678 0 vdd!) INV
U499 (n_246 n_137 0 vdd!) INV
U91 (X_183gat n_81 0 vdd!) INV
U30 (X_183gat n_555 0 vdd!) INV
U174 (n_696 n_695 0 vdd!) INV
U175 (n_696 n_694 0 vdd!) INV
U168 (n_703 n_702 0 vdd!) INV
U169 (n_703 n_701 0 vdd!) INV
U427 (n_556 n_207 0 vdd!) INV
U338 (n_691 n_403 0 vdd!) INV
U319 (n_697 n_449 0 vdd!) INV
U172 (n_699 n_697 0 vdd!) INV
U178 (n_693 n_691 0 vdd!) INV
U177 (n_693 n_692 0 vdd!) INV
U301 (n_717 n_488 0 vdd!) INV
U154 (n_719 n_717 0 vdd!) INV
U210 (n_657 n_653 0 vdd!) INV
U171 (n_699 n_698 0 vdd!) INV
U302 (n_724 n_487 0 vdd!) INV
U148 (n_726 n_724 0 vdd!) INV
U153 (n_719 n_718 0 vdd!) INV
U147 (n_726 n_725 0 vdd!) INV
U637 (n_627 n_501 0 vdd!) INV
U426 (n_311 n_208 0 vdd!) INV
U346 (n_79 n_385 0 vdd!) INV
U93 (n_81 n_79 0 vdd!) INV
U92 (n_81 n_80 0 vdd!) INV
U341 (n_89 n_395 0 vdd!) INV
U84 (n_91 n_89 0 vdd!) INV
U47 (n_378 n_367 0 vdd!) INV
U46 (n_628 n_378 0 vdd!) INV
U220 (n_648 n_645 0 vdd!) INV
U518 (n_224 n_117 0 vdd!) INV
U337 (n_741 n_404 0 vdd!) INV
U132 (n_743 n_741 0 vdd!) INV
U130 (X_71gat n_743 0 vdd!) INV
U20 (X_71gat n_666 0 vdd!) INV
U514 (n_229 n_121 0 vdd!) INV
U106 (X_99gat n_770 0 vdd!) INV
U13 (X_99gat n_744 0 vdd!) INV
U11 (X_106gat n_766 0 vdd!) INV
U100 (X_106gat n_776 0 vdd!) INV
U513 (n_230 n_122 0 vdd!) INV
U1 (X_78gat n_778 0 vdd!) INV
U124 (X_78gat n_750 0 vdd!) INV
U126 (n_750 n_748 0 vdd!) INV
U318 (n_748 n_450 0 vdd!) INV
U517 (n_225 n_118 0 vdd!) INV
U202 (n_664 n_663 0 vdd!) INV
U225 (n_642 n_639 0 vdd!) INV
U224 (n_642 n_640 0 vdd!) INV
U223 (n_672 n_638 0 vdd!) INV
U222 (n_672 n_641 0 vdd!) INV
U162 (n_709 n_708 0 vdd!) INV
U156 (n_716 n_715 0 vdd!) INV
U157 (n_716 n_714 0 vdd!) INV
U163 (n_709 n_707 0 vdd!) INV
U211 (n_657 n_654 0 vdd!) INV
U208 (n_504 n_657 0 vdd!) INV
U429 (n_711 n_205 0 vdd!) INV
U131 (n_743 n_742 0 vdd!) INV
U307 (n_768 n_477 0 vdd!) INV
U108 (n_770 n_768 0 vdd!) INV
U107 (n_770 n_769 0 vdd!) INV
U101 (n_776 n_775 0 vdd!) INV
U102 (n_776 n_774 0 vdd!) INV
U308 (n_774 n_476 0 vdd!) INV
U125 (n_750 n_749 0 vdd!) INV
U209 (n_289 n_656 0 vdd!) INV
U54 (n_504 n_289 0 vdd!) INV
U601 (n_624 n_504 0 vdd!) INV
U428 (n_467 n_206 0 vdd!) INV
U509 (n_235 n_126 0 vdd!) INV
U28 (X_120gat n_578 0 vdd!) INV
U88 (X_120gat n_85 0 vdd!) INV
U94 (X_113gat n_78 0 vdd!) INV
U26 (X_113gat n_600 0 vdd!) INV
U508 (n_236 n_127 0 vdd!) INV
U504 (n_240 n_131 0 vdd!) INV
U64 (X_148gat n_178 0 vdd!) INV
U8 (X_148gat n_94 0 vdd!) INV
U6 (X_141gat n_223 0 vdd!) INV
U70 (X_141gat n_111 0 vdd!) INV
U505 (n_239 n_130 0 vdd!) INV
U501 (n_243 n_135 0 vdd!) INV
U79 (X_169gat n_95 0 vdd!) INV
U32 (X_169gat n_533 0 vdd!) INV
U35 (X_176gat n_500 0 vdd!) INV
U85 (X_176gat n_88 0 vdd!) INV
U500 (n_244 n_136 0 vdd!) INV
U134 (n_740 n_739 0 vdd!) INV
U198 (n_670 n_669 0 vdd!) INV
U496 (n_249 n_140 0 vdd!) INV
U497 (n_248 n_139 0 vdd!) INV
U36 (n_619 n_489 0 vdd!) INV
U37 (n_489 n_478 0 vdd!) INV
U109 (X_204gat n_767 0 vdd!) INV
U14 (X_204gat n_733 0 vdd!) INV
U103 (X_197gat n_773 0 vdd!) INV
U12 (X_197gat n_755 0 vdd!) INV
U61 (n_222 n_211 0 vdd!) INV
U60 (n_668 n_222 0 vdd!) INV
U95 (n_78 n_77 0 vdd!) INV
U96 (n_78 n_76 0 vdd!) INV
U89 (n_85 n_84 0 vdd!) INV
U90 (n_85 n_82 0 vdd!) INV
U343 (n_82 n_393 0 vdd!) INV
U342 (n_76 n_394 0 vdd!) INV
U324 (n_156 n_438 0 vdd!) INV
U66 (n_178 n_156 0 vdd!) INV
U65 (n_178 n_167 0 vdd!) INV
U72 (n_111 n_102 0 vdd!) INV
U71 (n_111 n_103 0 vdd!) INV
U323 (n_102 n_439 0 vdd!) INV
U347 (n_92 n_384 0 vdd!) INV
U81 (n_95 n_92 0 vdd!) INV
U206 (n_267 n_658 0 vdd!) INV
U80 (n_95 n_93 0 vdd!) INV
U86 (n_88 n_87 0 vdd!) INV
U87 (n_88 n_86 0 vdd!) INV
U348 (n_86 n_383 0 vdd!) INV
U329 (n_764 n_428 0 vdd!) INV
U111 (n_767 n_764 0 vdd!) INV
U199 (n_670 n_668 0 vdd!) INV
U197 (n_502 n_670 0 vdd!) INV
U328 (n_771 n_429 0 vdd!) INV
U105 (n_773 n_771 0 vdd!) INV
U205 (n_661 n_660 0 vdd!) INV
U135 (n_740 n_738 0 vdd!) INV
U151 (n_723 n_720 0 vdd!) INV
U150 (n_723 n_721 0 vdd!) INV
U110 (n_767 n_765 0 vdd!) INV
U104 (n_773 n_772 0 vdd!) INV
U506 (n_238 n_129 0 vdd!) INV
U42 (n_625 n_422 0 vdd!) INV
U43 (n_422 n_411 0 vdd!) INV
U34 (n_522 n_511 0 vdd!) INV
U33 (n_618 n_522 0 vdd!) INV
U219 (n_648 n_646 0 vdd!) INV
U217 (n_671 n_647 0 vdd!) INV
U649 (n_598 n_502 0 vdd!) INV
U215 (n_652 n_650 0 vdd!) INV
U183 (n_508 n_685 0 vdd!) INV
U554 (n_629 n_626 0 vdd!) INV
U204 (n_508 n_661 0 vdd!) INV
U55 (n_661 n_278 0 vdd!) INV
U56 (n_278 n_267 0 vdd!) INV
U207 (n_267 n_659 0 vdd!) INV
U179 (n_502 n_690 0 vdd!) INV
U23 (X_162gat n_633 0 vdd!) INV
U73 (X_162gat n_101 0 vdd!) INV
U76 (X_134gat n_98 0 vdd!) INV
U25 (X_134gat n_611 0 vdd!) INV
U502 (n_242 n_133 0 vdd!) INV
U145 (n_729 n_727 0 vdd!) INV
U214 (n_652 n_649 0 vdd!) INV
U4 (X_155gat n_445 0 vdd!) INV
U67 (X_155gat n_145 0 vdd!) INV
U69 (n_145 n_123 0 vdd!) INV
U322 (n_123 n_440 0 vdd!) INV
U503 (n_241 n_132 0 vdd!) INV
U83 (n_91 n_90 0 vdd!) INV
U82 (X_127gat n_91 0 vdd!) INV
U24 (X_127gat n_622 0 vdd!) INV
U203 (n_664 n_662 0 vdd!) INV
U201 (n_501 n_664 0 vdd!) INV
U200 (n_501 n_665 0 vdd!) INV
U58 (n_256 n_245 0 vdd!) INV
U128 (n_747 n_746 0 vdd!) INV
U213 (n_300 n_651 0 vdd!) INV
U129 (n_747 n_745 0 vdd!) INV
U144 (n_729 n_728 0 vdd!) INV
U424 (n_345 n_210 0 vdd!) INV
U77 (n_98 n_97 0 vdd!) INV
U78 (n_98 n_96 0 vdd!) INV
U74 (n_101 n_100 0 vdd!) INV
U75 (n_101 n_99 0 vdd!) INV
U298 (n_99 n_496 0 vdd!) INV
U68 (n_145 n_134 0 vdd!) INV
U297 (n_96 n_497 0 vdd!) INV
U57 (n_662 n_256 0 vdd!) INV
U212 (n_626 n_652 0 vdd!) INV
U661 (n_595 n_508 0 vdd!) INV
U53 (n_626 n_300 0 vdd!) INV
U425 (n_334 n_209 0 vdd!) INV
U498 (n_247 n_138 0 vdd!) INV
U295 (n_73 n_499 0 vdd!) INV
U99 (n_75 n_73 0 vdd!) INV
U494 (n_251 n_142 0 vdd!) INV
U117 (n_760 n_758 0 vdd!) INV
U327 (n_758 n_430 0 vdd!) INV
U495 (n_250 n_141 0 vdd!) INV
U194 (n_675 n_673 0 vdd!) INV
U188 (n_322 n_680 0 vdd!) INV
U97 (X_190gat n_75 0 vdd!) INV
U29 (X_190gat n_567 0 vdd!) INV
U27 (X_218gat n_589 0 vdd!) INV
U121 (X_218gat n_753 0 vdd!) INV
U10 (X_211gat n_777 0 vdd!) INV
U115 (X_211gat n_760 0 vdd!) INV
U192 (n_635 n_675 0 vdd!) INV
U229 (n_681 n_635 0 vdd!) INV
U187 (X_233gat n_681 0 vdd!) INV
U226 (X_233gat n_637 0 vdd!) INV
U98 (n_75 n_74 0 vdd!) INV
U122 (n_753 n_752 0 vdd!) INV
U123 (n_753 n_751 0 vdd!) INV
U296 (n_751 n_498 0 vdd!) INV
U116 (n_760 n_759 0 vdd!) INV
U431 (n_689 n_203 0 vdd!) INV
U430 (n_444 n_204 0 vdd!) INV
U63 (n_200 n_189 0 vdd!) INV
U193 (n_675 n_674 0 vdd!) INV
U230 (n_681 n_634 0 vdd!) INV
U62 (n_632 n_200 0 vdd!) INV
U228 (n_322 n_632 0 vdd!) INV
U51 (n_333 n_322 0 vdd!) INV
U59 (n_200 n_234 0 vdd!) INV
U227 (n_637 n_636 0 vdd!) INV
U50 (n_637 n_333 0 vdd!) INV
U294 (n_650 n_627 n_608 0 vdd!) NOR2
U235 (n_641 n_289 n_619 0 vdd!) NOR2
U289 (n_654 n_640 n_505 0 vdd!) NOR2
U236 (n_646 n_734 n_618 0 vdd!) NOR2
U283 (n_659 n_690 n_630 0 vdd!) NOR2
simulatorOptions options temp=27
