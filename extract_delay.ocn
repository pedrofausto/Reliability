;para mexer com arquivo, precisa abrir ports (também é bom fechá-los, mas não fiz aqui):
;in_expression=infile("./expression_delay_ocean.ocn")
out_delay=outfile("./delays_inv.csv", "a")

fprintf(out_delay "\n\t** Delays for gate inv **")
fprintf(out_delay "\n\t\tDelay to N Aged years (seconds) - vdd1.1 - temp25")
fprintf(out_delay "\nFrom year\tTo year")
fprintf(out_delay "\n\t1 year\t3 years\t5 years\t7 years\t10 years")

result=delay(?wf1 v("Y" ?result "tran" ?resultsDir "./invAge_vdd1.1_temp25_Age1d"), ?value1 0.5, ?edge1 "falling", ?nth1 1, ?td1 0.0, ?wf2 v("Y" ?result "tran" ?resultsDir "./invAge_vdd1.1_temp25_Age1y"), ?value2 0.5, ?edge2 "falling", ?nth2 1,  ?td2 0.0 , ?stop nil, ?multiple nil)
fprintf(out_delay "\nPristine \t%.4e" result)
result=delay(?wf1 v("Y" ?result "tran" ?resultsDir "./invAge_vdd1.1_temp25_Age1d"), ?value1 0.5, ?edge1 "falling", ?nth1 1, ?td1 0.0, ?wf2 v("Y" ?result "tran" ?resultsDir "./invAge_vdd1.1_temp25_Age3y"), ?value2 0.5, ?edge2 "falling", ?nth2 1,  ?td2 0.0 , ?stop nil, ?multiple nil)
fprintf(out_delay "\t%.4e" result)
result=delay(?wf1 v("Y" ?result "tran" ?resultsDir "./invAge_vdd1.1_temp25_Age1d"), ?value1 0.5, ?edge1 "falling", ?nth1 1, ?td1 0.0, ?wf2 v("Y" ?result "tran" ?resultsDir "./invAge_vdd1.1_temp25_Age5y"), ?value2 0.5, ?edge2 "falling", ?nth2 1,  ?td2 0.0 , ?stop nil, ?multiple nil)
fprintf(out_delay "\t%.4e" result)
result=delay(?wf1 v("Y" ?result "tran" ?resultsDir "./invAge_vdd1.1_temp25_Age1d"), ?value1 0.5, ?edge1 "falling", ?nth1 1, ?td1 0.0, ?wf2 v("Y" ?result "tran" ?resultsDir "./invAge_vdd1.1_temp25_Age7y"), ?value2 0.5, ?edge2 "falling", ?nth2 1,  ?td2 0.0 , ?stop nil, ?multiple nil)
fprintf(out_delay "\t%.4e" result)
result=delay(?wf1 v("Y" ?result "tran" ?resultsDir "./invAge_vdd1.1_temp25_Age1d"), ?value1 0.5, ?edge1 "falling", ?nth1 1, ?td1 0.0, ?wf2 v("Y" ?result "tran" ?resultsDir "./invAge_vdd1.1_temp25_Age10y"), ?value2 0.5, ?edge2 "falling", ?nth2 1,  ?td2 0.0 , ?stop nil, ?multiple nil)
fprintf(out_delay "\t%.4e" result)

result=delay(?wf1 v("Y" ?result "tran" ?resultsDir "./invAge_vdd1.1_temp25_Age1y"), ?value1 0.5, ?edge1 "falling", ?nth1 1, ?td1 0.0, ?wf2 v("Y" ?result "tran" ?resultsDir "./invAge_vdd1.1_temp25_Age3y"), ?value2 0.5, ?edge2 "falling", ?nth2 1,  ?td2 0.0 , ?stop nil, ?multiple nil)
fprintf(out_delay "\n1year\t\t%.4e" result)
result=delay(?wf1 v("Y" ?result "tran" ?resultsDir "./invAge_vdd1.1_temp25_Age1y"), ?value1 0.5, ?edge1 "falling", ?nth1 1, ?td1 0.0, ?wf2 v("Y" ?result "tran" ?resultsDir "./invAge_vdd1.1_temp25_Age5y"), ?value2 0.5, ?edge2 "falling", ?nth2 1,  ?td2 0.0 , ?stop nil, ?multiple nil)
fprintf(out_delay "\t%.4e" result)
result=delay(?wf1 v("Y" ?result "tran" ?resultsDir "./invAge_vdd1.1_temp25_Age1y"), ?value1 0.5, ?edge1 "falling", ?nth1 1, ?td1 0.0, ?wf2 v("Y" ?result "tran" ?resultsDir "./invAge_vdd1.1_temp25_Age7y"), ?value2 0.5, ?edge2 "falling", ?nth2 1,  ?td2 0.0 , ?stop nil, ?multiple nil)
fprintf(out_delay "\t%.4e" result)
result=delay(?wf1 v("Y" ?result "tran" ?resultsDir "./invAge_vdd1.1_temp25_Age1y"), ?value1 0.5, ?edge1 "falling", ?nth1 1, ?td1 0.0, ?wf2 v("Y" ?result "tran" ?resultsDir "./invAge_vdd1.1_temp25_Age10y"), ?value2 0.5, ?edge2 "falling", ?nth2 1,  ?td2 0.0 , ?stop nil, ?multiple nil)
fprintf(out_delay "\t%.4e" result)

result=delay(?wf1 v("Y" ?result "tran" ?resultsDir "./invAge_vdd1.1_temp25_Age3y"), ?value1 0.5, ?edge1 "falling", ?nth1 1, ?td1 0.0, ?wf2 v("Y" ?result "tran" ?resultsDir "./invAge_vdd1.1_temp25_Age5y"), ?value2 0.5, ?edge2 "falling", ?nth2 1,  ?td2 0.0 , ?stop nil, ?multiple nil)
fprintf(out_delay "\n3years\t\t\t%.4e" result)
result=delay(?wf1 v("Y" ?result "tran" ?resultsDir "./invAge_vdd1.1_temp25_Age3y"), ?value1 0.5, ?edge1 "falling", ?nth1 1, ?td1 0.0, ?wf2 v("Y" ?result "tran" ?resultsDir "./invAge_vdd1.1_temp25_Age7y"), ?value2 0.5, ?edge2 "falling", ?nth2 1,  ?td2 0.0 , ?stop nil, ?multiple nil)
fprintf(out_delay "\t%.4e" result)
result=delay(?wf1 v("Y" ?result "tran" ?resultsDir "./invAge_vdd1.1_temp25_Age3y"), ?value1 0.5, ?edge1 "falling", ?nth1 1, ?td1 0.0, ?wf2 v("Y" ?result "tran" ?resultsDir "./invAge_vdd1.1_temp25_Age10y"), ?value2 0.5, ?edge2 "falling", ?nth2 1,  ?td2 0.0 , ?stop nil, ?multiple nil)
fprintf(out_delay "\t%.4e" result)

result=delay(?wf1 v("Y" ?result "tran" ?resultsDir "./invAge_vdd1.1_temp25_Age5y"), ?value1 0.5, ?edge1 "falling", ?nth1 1, ?td1 0.0, ?wf2 v("Y" ?result "tran" ?resultsDir "./invAge_vdd1.1_temp25_Age7y"), ?value2 0.5, ?edge2 "falling", ?nth2 1,  ?td2 0.0 , ?stop nil, ?multiple nil)
fprintf(out_delay "\n5years\t\t\t\t%.4e" result)
result=delay(?wf1 v("Y" ?result "tran" ?resultsDir "./invAge_vdd1.1_temp25_Age5y"), ?value1 0.5, ?edge1 "falling", ?nth1 1, ?td1 0.0, ?wf2 v("Y" ?result "tran" ?resultsDir "./invAge_vdd1.1_temp25_Age10y"), ?value2 0.5, ?edge2 "falling", ?nth2 1,  ?td2 0.0 , ?stop nil, ?multiple nil)
fprintf(out_delay "\t%.4e" result)

result=delay(?wf1 v("Y" ?result "tran" ?resultsDir "./invAge_vdd1.1_temp25_Age7y"), ?value1 0.5, ?edge1 "falling", ?nth1 1, ?td1 0.0, ?wf2 v("Y" ?result "tran" ?resultsDir "./invAge_vdd1.1_temp25_Age10y"), ?value2 0.5, ?edge2 "falling", ?nth2 1,  ?td2 0.0 , ?stop nil, ?multiple nil)
fprintf(out_delay "\n7years\t\t\t\t\t%.4e" result)
fprintf(out_delay "\n")
fprintf(out_delay "\n")

drain(out_delay)

close(out_delay)
