;Extract script file for inv100_vdd11_temp55_act20_period40us_age16012h
out_delay=outfile("./delays_inv.csv", "a")
fprintf(out_delay ";Extract results file for inv100_vdd11_temp55_act20_period40us_age16012h\n")
result1=delay(?wf1 v("Y" ?result "tran" ?resultsDir "./inv100_vdd11_temp25_act20_period40us_age1000h"), ?value1 1.1, ?edge1 "rising", ?nth1 1, ?td1 0.0, ?wf2 v("Y" ?result "tran" ?resultsDir "./inv100_vdd11_temp30_act20_period40us_age8012h"), ?value2 1.1, ?edge2 "rising", ?nth2 1,  ?td2 0.0 , ?stop nil, ?multiple nil)\n
result2=delay(?wf1 v("Y" ?result "tran" ?resultsDir "./inv100_vdd11_temp25_act20_period40us_age1000h"), ?value1 1.1, ?edge1 "falling", ?nth1 1, ?td1 0.0, ?wf2 v("Y" ?result "tran" ?resultsDir "./inv100_vdd11_temp30_act20_period40us_age8012h"), ?value2 1.1, ?edge2 "falling", ?nth2 1,  ?td2 0.0 , ?stop nil, ?multiple nil)\n
result1=delay(?wf1 v("Y" ?result "tran" ?resultsDir "./inv100_vdd11_temp25_act20_period40us_age1000h"), ?value1 1.1, ?edge1 "rising", ?nth1 1, ?td1 0.0, ?wf2 v("Y" ?result "tran" ?resultsDir "./inv100_vdd11_temp55_act20_period40us_age16012h"), ?value2 1.1, ?edge2 "rising", ?nth2 1,  ?td2 0.0 , ?stop nil, ?multiple nil)\n
result2=delay(?wf1 v("Y" ?result "tran" ?resultsDir "./inv100_vdd11_temp25_act20_period40us_age1000h"), ?value1 1.1, ?edge1 "falling", ?nth1 1, ?td1 0.0, ?wf2 v("Y" ?result "tran" ?resultsDir "./inv100_vdd11_temp55_act20_period40us_age16012h"), ?value2 1.1, ?edge2 "falling", ?nth2 1,  ?td2 0.0 , ?stop nil, ?multiple nil)\n
drain(out_delay)
close(out_delay)
